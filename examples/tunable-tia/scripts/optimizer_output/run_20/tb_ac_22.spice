** sch_path: /foss/designs/eda/SymXplorer/examples/tunable-tia/ihp-sg13g2/xschem/tb_ac.sch
**.subckt tb_ac
V0 VSS GND 0
V2 VDD GND {vdd}
V1 Vbias GND {vbias}
C1 Von GND {cload} m=1
C2 Vop GND {cload} m=1
Icm In GND {icm}
Idn In GND dc 0 ac -0.5
Icm1 Ip GND {icm}
Idp Ip GND dc 0 ac 0.5
x_dut VDD Vop VSS Von Vbias In Ip tia-bpf-1-ideal-ind
**** begin user architecture code

****** START OF CONTROL SECTION ******

.control

    echo ==================================
    echo start of Control
    echo ==================================

    save all

    echo
    echo (A) start of OP
    echo ----------------------------------

    * operating point
    op

    *let gm = n.x_dut.xm1.nsg13_lv_nmos[gm]
    *let id = n.x_dut.xm1.nsg13_lv_nmos[id]
    *let gmid = gm/id

    print all

    write op.raw

    echo ----------------------------------
    echo END of OP
    echo ----------------------------------

    set appendwrite

    echo
    echo (B) start of AC Sim
    echo ----------------------------------

    * run ac simulation
    ac dec 200 1e-3 1e12

    echo (1) post processing the AC sim
    * magnitude
    let Vout = v(Vop) - v(Von)
    let vout_mag = abs(v(Vout))
    let vout_mag_db = 20*log(vout_mag)/log(10)

    * raw phase (between -180 and 180)
    let vout_phase = phase(v(Vout)) * 180/pi

    echo (2) measuring A0, PM, UGF...

    * Bandpass response parameters
    meas ac GMAX max vout_mag

    let gmax_3db = GMAX/sqrt(2)

    meas ac FLO when vout_mag=gmax_3db cross=1
    meas ac FHI when vout_mag=gmax_3db cross=2

    let BW = FHI-FLO
    let FC = (FHI+FLO)/2.0
    let Q  = FC/BW
    let gain_db = 20 * log(GMAX) / log(10)
    print BW Q gain_db
    *meas ac A0 find vout_mag at=1k
    meas ac PM find vout_phase when vout_mag=1
    meas ac UGF when vout_mag=1 fall=1

    echo (3) plotting...
    plot vout_mag

    echo ----------------------------------
    echo END of AC sim
    echo  ----------------------------------

    echo SAVING SIMULATION RESULTS IN THE RAW FILE
    save all
    write

    echo ==================================
    echo END of Control
    echo ==================================
    quit
.endc
******  END OF CONTROL SECTION ******

********** Models ************
.lib cornerMOSlv.lib mos_tt
.lib cornerRES.lib res_typ
.lib /foss/pdks/ihp-sg13g2/libs.tech/ngspice/models/cornerCAP.lib cap_typ
********** END of Models ************

****** Save Statements ******
*.option savecurrents

** nfet small signal parameters **
.save @n.x_dut.xm1.nsg13_lv_nmos[cdd]
.save @n.x_dut.xm1.nsg13_lv_nmos[cgb]
.save @n.x_dut.xm1.nsg13_lv_nmos[cgd]
.save @n.x_dut.xm1.nsg13_lv_nmos[cgdol]
.save @n.x_dut.xm1.nsg13_lv_nmos[cgg]
.save @n.x_dut.xm1.nsg13_lv_nmos[cgs]
.save @n.x_dut.xm1.nsg13_lv_nmos[cgsol]
.save @n.x_dut.xm1.nsg13_lv_nmos[cjd]
.save @n.x_dut.xm1.nsg13_lv_nmos[cjs]
.save @n.x_dut.xm1.nsg13_lv_nmos[css]
.save @n.x_dut.xm1.nsg13_lv_nmos[gds]
.save @n.x_dut.xm1.nsg13_lv_nmos[gm]
.save @n.x_dut.xm1.nsg13_lv_nmos[gmb]
.save @n.x_dut.xm1.nsg13_lv_nmos[ids]
.save @n.x_dut.xm1.nsg13_lv_nmos[l]
.save @n.x_dut.xm1.nsg13_lv_nmos[sfl]
.save @n.x_dut.xm1.nsg13_lv_nmos[sid]
.save @n.x_dut.xm1.nsg13_lv_nmos[vth]

.save @n.x_dut.xm1.nsg13_lv_nmos[vgs]
.save @n.x_dut.xm1.nsg13_lv_nmos[vds]
.save @n.x_dut.xm1.nsg13_lv_nmos[vdss]

******  End of Save Statements ******

****** TB Parameters ******
.param icm=0.5e-6
.param vdd=1.2
.param vbias=0.25
.param cload=100p
******  End of TB Params ******

****** All DUT parameters ******

* MOSFET PARAMETERS
.param x_dut_nfet_w= 1.4344101185391531
.param x_dut_nfet_l= 0.00047804038861590085
.param x_dut_nfet_m=10

* PASSIVE ELEMENT PARAMETERS

.param x_dut_cap_l= 0.00034100913202143326
.param x_dut_cap_w= 0.0003767391615076715
.param x_dut_cap_m=10

.param x_dut_res_s_l= 0.0003079499126593587
.param x_dut_res_s_w= 0.00048620531085322817
.param x_dut_res_s_m=1

.param x_dut_res_3_l= 0.00048770315140412733
.param x_dut_res_3_w= 0.0005910342383089154
.param x_dut_res_3_m=1

.param x_dut_ind_size=1n

****** END of DUT Params ******

**** end user architecture code
**.ends

* expanding   symbol:  tia-bpf-1-ideal-ind.sym # of pins=7
** sym_path: /foss/designs/eda/SymXplorer/examples/tunable-tia/ihp-sg13g2/xschem/tia-bpf-1-ideal-ind.sym
** sch_path: /foss/designs/eda/SymXplorer/examples/tunable-tia/ihp-sg13g2/xschem/tia-bpf-1-ideal-ind.sch
.subckt tia-bpf-1-ideal-ind vdd vop vss von vbias inn inp
*.iopin vdd
*.iopin vss
*.ipin inp
*.ipin inn
*.opin von
*.opin vop
*.ipin vbias
XM1 vop vbias inn vss sg13_lv_nmos w={x_dut_nfet_w} l={x_dut_nfet_l} ng=1 m={x_dut_nfet_m} rfmode=1
XM2 von vbias inp vss sg13_lv_nmos w={x_dut_nfet_w} l={x_dut_nfet_l} ng=1 m={x_dut_nfet_m} rfmode=1
XC1 vdd von cap_cmim w={x_dut_cap_w} l={x_dut_cap_l} m={x_dut_cap_m}
XC2 vdd vop cap_cmim w={x_dut_cap_w} l={x_dut_cap_l} m={x_dut_cap_m}
XR1 vss inp rppd w={x_dut_res_s_w} l={x_dut_res_s_l} m={x_dut_res_s_m} b=0
XR2 vss inn rppd w={x_dut_res_s_w} l={x_dut_res_s_l} m={x_dut_res_s_m} b=0
XR3 vop von rppd w={x_dut_res_3_w} l={x_dut_res_3_l} m={x_dut_res_3_m} b=0
L2 vdd von {x_dut_ind_size} m=1
L3 vdd vop m=1
.ends

.GLOBAL GND
.end
