** sch_path: /foss/designs/eda/SymXplorer/examples/tunable-tia/tia-bpf-1/bpf-tia-1-all-r-c.sch
.subckt bpf-tia-1-all-r-c vdd vss vop von inn inp vbias
*.PININFO vdd:B vss:B inp:I inn:I von:O vop:O vbias:I
M1 von vbias inp vss nfet_03v3 L={x_dut_m1_2_l} W={x_dut_m1_2_w} nf=2 m=1
M2 vop vbias inn vss nfet_03v3 L={x_dut_m1_2_l} W={x_dut_m1_2_w} nf=2 m=1
R1 inp vss {x_dut_rs} m=1
R2 inn vss {x_dut_rs} m=1
C1 vdd von {x_dut_cdd} m=1
C2 vdd vop {x_dut_cdd} m=1
L2 vdd von {x_dut_ldd} m=1
L3 vdd vop {x_dut_ldd} m=1
R4 von vop {x_dut_r4} m=1
.ends
