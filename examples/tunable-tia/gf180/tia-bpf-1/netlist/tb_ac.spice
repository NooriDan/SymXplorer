** sch_path: /foss/designs/eda/SymXplorer/examples/tunable-tia/tia-bpf-1/tb_ac.sch
**.subckt tb_ac
V0 VSS GND 0
V2 VDD GND {vdd}
x_dut VDD VSS Vop Von In Ip Vbias bpf-tia-1-all-r-c
V1 Vbias GND {vbias}
C1 Von GND {cload} m=1
C2 Vop GND {cload} m=1
Icm In GND {icm}
Idn In GND ac -0.5
Icm1 Ip GND {icm}
Idp Ip GND ac 0.5
**** begin user architecture code

.control

    echo ==================================
    echo start of Control
    echo ==================================

    save all

    echo
    echo (A) start of OP
    echo ----------------------------------

    * operating point
    op
    let gm_id = @m.x_dut.xm1.m0[gm]/@m.x_dut.xm1.m0[id]
    print all
    write

    echo ----------------------------------
    echo END of OP
    echo ----------------------------------

    set appendwrite

    echo
    echo (B) start of AC Sim
    echo ----------------------------------

    * run ac simulation
    ac dec 200 1e5 1e12

    echo (1) post processing the AC sim
    * magnitude
    let Vout = v(Vop) - v(Von)
    let vout_mag = abs(v(Vout))
    let vout_mag_db = 20*log(vout_mag)/log(10)

    * raw phase (between -180 and 180)
    let vout_phase = phase(v(Vout)) * 180/pi

    echo (2) measuring A0, PM, UGF...

    * Bandpass response parameters
    meas ac GMAX max vout_mag
    meas ac FC when vout_mag=GMAX

    let gmax_3db = GMAX/sqrt(2)

    meas ac FLO when vout_mag=gmax_3db cross=1
    meas ac FHI when vout_mag=gmax_3db cross=2

    let BW = FHI-FLO
    let Q  = FC/BW
    let gain_db = 20 * log(GMAX) / log(10)
    print BW Q gain_db
    *meas ac A0 find vout_mag at=1k
    meas ac PM find vout_phase when vout_mag=1
    meas ac UGF when vout_mag=1 fall=1

    echo (3) plotting...
    plot vout_mag

    echo ----------------------------------
    echo END of AC sim
    echo  ----------------------------------

    echo SAVING SIMULATION RESULTS IN THE RAW FILE
    save all
    write

    echo ==================================
    echo END of Control
    echo ==================================
    quit
.endc

.include /foss/pdks/gf180mcuD/libs.tech/ngspice/design.ngspice
.lib /foss/pdks/gf180mcuD/libs.tech/ngspice/sm141064.ngspice typical

.lib /foss/pdks/gf180mcuD/libs.tech/ngspice/sm141064.ngspice res_typical
* .lib /foss/pdks/gf180mcuD/libs.tech/ngspice/sm141064.ngspice res_statistical

*.option savecurrents
* Saving gm values for transistors
.save @m.x_dut.xm1.m0[gm]
.save @m.x_dut.xm2.m0[gm]

* Saving id values for transistors
.save @m.x_dut.xm1.m0[id]
.save @m.x_dut.xm2.m0[id]

* TB Parameters
.param idd=1.8e-6
.param icm=0.5e-6
.param vdd=6.0
.param vbias=1.0
.param cload=1p

* All DUT parameters

* MOSFET PARAMETERS
.param x_dut_m1_2_w=0.22u
.param x_dut_m1_2_l=0.40u
.param x_dut_m1_2_nf=2

* PASSIVE ELEMENT PARAMETERS
.param x_dut_ldd=2n
.param x_dut_cdd=1n

.param x_dut_rs=1k

.param x_dut_r4=1k

**** end user architecture code
**.ends

* expanding   symbol:  tia-bpf-1/bpf-tia-1-all-r-c.sym # of pins=7
** sym_path: /foss/designs/eda/SymXplorer/examples/tunable-tia/tia-bpf-1/bpf-tia-1-all-r-c.sym
** sch_path: /foss/designs/eda/SymXplorer/examples/tunable-tia/tia-bpf-1/bpf-tia-1-all-r-c.sch
.subckt bpf-tia-1-all-r-c vdd vss vop von inn inp vbias
*.iopin vdd
*.iopin vss
*.ipin inp
*.ipin inn
*.opin von
*.opin vop
*.ipin vbias
XM1 von vbias inp vss nfet_03v3 L={x_dut_m1_2_l} W={x_dut_m1_2_w} nf=2 ad='int((nf+1)/2) * W/nf * 0.18u' as='int((nf+2)/2) * W/nf * 0.18u'
+ pd='2*int((nf+1)/2) * (W/nf + 0.18u)' ps='2*int((nf+2)/2) * (W/nf + 0.18u)' nrd='0.18u / W' nrs='0.18u / W' sa=0 sb=0 sd=0 m=1
XM2 vop vbias inn vss nfet_03v3 L={x_dut_m1_2_l} W={x_dut_m1_2_w} nf=2 ad='int((nf+1)/2) * W/nf * 0.18u' as='int((nf+2)/2) * W/nf * 0.18u'
+ pd='2*int((nf+1)/2) * (W/nf + 0.18u)' ps='2*int((nf+2)/2) * (W/nf + 0.18u)' nrd='0.18u / W' nrs='0.18u / W' sa=0 sb=0 sd=0 m=1
R1 inp vss {x_dut_rs} m=1
R2 inn vss {x_dut_rs} m=1
C1 vdd von {x_dut_cdd} m=1
C2 vdd vop {x_dut_cdd} m=1
L2 vdd von {x_dut_ldd} m=1
L3 vdd vop {x_dut_ldd} m=1
R4 von vop {x_dut_r4} m=1
.ends

.GLOBAL GND
.end
